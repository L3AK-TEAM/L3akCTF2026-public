.title Digital is a Scam
.option abstol=1e-30 reltol=1e-18 vabstol=1e-30 numdgt=15
.param VREF=1

.param CUNIT=1f
CSEG000 cdac000 cdac001 {CUNIT}
CBIT000 cdac000 flag000 {2*CUNIT}
CSEG001 cdac001 cdac002 {CUNIT}
CBIT001 cdac001 flag001 {2*CUNIT}
CSEG002 cdac002 cdac003 {CUNIT}
CBIT002 cdac002 flag002 {2*CUNIT}
CSEG003 cdac003 cdac004 {CUNIT}
CBIT003 cdac003 flag003 {2*CUNIT}
CSEG004 cdac004 cdac005 {CUNIT}
CBIT004 cdac004 flag004 {2*CUNIT}
CSEG005 cdac005 cdac006 {CUNIT}
CBIT005 cdac005 flag005 {2*CUNIT}
CSEG006 cdac006 cdac007 {CUNIT}
CBIT006 cdac006 flag006 {2*CUNIT}
CSEG007 cdac007 cdac008 {CUNIT}
CBIT007 cdac007 flag007 {2*CUNIT}
CSEG008 cdac008 cdac009 {CUNIT}
CBIT008 cdac008 flag008 {2*CUNIT}
CSEG009 cdac009 cdac010 {CUNIT}
CBIT009 cdac009 flag009 {2*CUNIT}
CSEG010 cdac010 cdac011 {CUNIT}
CBIT010 cdac010 flag010 {2*CUNIT}
CSEG011 cdac011 cdac012 {CUNIT}
CBIT011 cdac011 flag011 {2*CUNIT}
CSEG012 cdac012 cdac013 {CUNIT}
CBIT012 cdac012 flag012 {2*CUNIT}
CSEG013 cdac013 cdac014 {CUNIT}
CBIT013 cdac013 flag013 {2*CUNIT}
CSEG014 cdac014 cdac015 {CUNIT}
CBIT014 cdac014 flag014 {2*CUNIT}
CSEG015 cdac015 cdac016 {CUNIT}
CBIT015 cdac015 flag015 {2*CUNIT}
CSEG016 cdac016 cdac017 {CUNIT}
CBIT016 cdac016 flag016 {2*CUNIT}
CSEG017 cdac017 cdac018 {CUNIT}
CBIT017 cdac017 flag017 {2*CUNIT}
CSEG018 cdac018 cdac019 {CUNIT}
CBIT018 cdac018 flag018 {2*CUNIT}
CSEG019 cdac019 cdac020 {CUNIT}
CBIT019 cdac019 flag019 {2*CUNIT}
CSEG020 cdac020 cdac021 {CUNIT}
CBIT020 cdac020 flag020 {2*CUNIT}
CSEG021 cdac021 cdac022 {CUNIT}
CBIT021 cdac021 flag021 {2*CUNIT}
CSEG022 cdac022 cdac023 {CUNIT}
CBIT022 cdac022 flag022 {2*CUNIT}
CSEG023 cdac023 cdac024 {CUNIT}
CBIT023 cdac023 flag023 {2*CUNIT}
CSEG024 cdac024 cdac025 {CUNIT}
CBIT024 cdac024 flag024 {2*CUNIT}
CSEG025 cdac025 cdac026 {CUNIT}
CBIT025 cdac025 flag025 {2*CUNIT}
CSEG026 cdac026 cdac027 {CUNIT}
CBIT026 cdac026 flag026 {2*CUNIT}
CSEG027 cdac027 cdac028 {CUNIT}
CBIT027 cdac027 flag027 {2*CUNIT}
CSEG028 cdac028 cdac029 {CUNIT}
CBIT028 cdac028 flag028 {2*CUNIT}
CSEG029 cdac029 cdac030 {CUNIT}
CBIT029 cdac029 flag029 {2*CUNIT}
CSEG030 cdac030 cdac031 {CUNIT}
CBIT030 cdac030 flag030 {2*CUNIT}
CSEG031 cdac031 cdac032 {CUNIT}
CBIT031 cdac031 flag031 {2*CUNIT}
CSEG032 cdac032 cdac033 {CUNIT}
CBIT032 cdac032 flag032 {2*CUNIT}
CSEG033 cdac033 cdac034 {CUNIT}
CBIT033 cdac033 flag033 {2*CUNIT}
CSEG034 cdac034 cdac035 {CUNIT}
CBIT034 cdac034 flag034 {2*CUNIT}
CSEG035 cdac035 cdac036 {CUNIT}
CBIT035 cdac035 flag035 {2*CUNIT}
CSEG036 cdac036 cdac037 {CUNIT}
CBIT036 cdac036 flag036 {2*CUNIT}
CSEG037 cdac037 cdac038 {CUNIT}
CBIT037 cdac037 flag037 {2*CUNIT}
CSEG038 cdac038 cdac039 {CUNIT}
CBIT038 cdac038 flag038 {2*CUNIT}
CSEG039 cdac039 cdac040 {CUNIT}
CBIT039 cdac039 flag039 {2*CUNIT}
CSEG040 cdac040 cdac041 {CUNIT}
CBIT040 cdac040 flag040 {2*CUNIT}
CSEG041 cdac041 cdac042 {CUNIT}
CBIT041 cdac041 flag041 {2*CUNIT}
CSEG042 cdac042 cdac043 {CUNIT}
CBIT042 cdac042 flag042 {2*CUNIT}
CSEG043 cdac043 cdac044 {CUNIT}
CBIT043 cdac043 flag043 {2*CUNIT}
CSEG044 cdac044 cdac045 {CUNIT}
CBIT044 cdac044 flag044 {2*CUNIT}
CSEG045 cdac045 cdac046 {CUNIT}
CBIT045 cdac045 flag045 {2*CUNIT}
CSEG046 cdac046 cdac047 {CUNIT}
CBIT046 cdac046 flag046 {2*CUNIT}
CSEG047 cdac047 cdac048 {CUNIT}
CBIT047 cdac047 flag047 {2*CUNIT}
CSEG048 cdac048 cdac049 {CUNIT}
CBIT048 cdac048 flag048 {2*CUNIT}
CSEG049 cdac049 cdac050 {CUNIT}
CBIT049 cdac049 flag049 {2*CUNIT}
CSEG050 cdac050 cdac051 {CUNIT}
CBIT050 cdac050 flag050 {2*CUNIT}
CSEG051 cdac051 cdac052 {CUNIT}
CBIT051 cdac051 flag051 {2*CUNIT}
CSEG052 cdac052 cdac053 {CUNIT}
CBIT052 cdac052 flag052 {2*CUNIT}
CSEG053 cdac053 cdac054 {CUNIT}
CBIT053 cdac053 flag053 {2*CUNIT}
CSEG054 cdac054 cdac055 {CUNIT}
CBIT054 cdac054 flag054 {2*CUNIT}
CSEG055 cdac055 cdac056 {CUNIT}
CBIT055 cdac055 flag055 {2*CUNIT}
CSEG056 cdac056 cdac057 {CUNIT}
CBIT056 cdac056 flag056 {2*CUNIT}
CSEG057 cdac057 cdac058 {CUNIT}
CBIT057 cdac057 flag057 {2*CUNIT}
CSEG058 cdac058 cdac059 {CUNIT}
CBIT058 cdac058 flag058 {2*CUNIT}
CSEG059 cdac059 cdac060 {CUNIT}
CBIT059 cdac059 flag059 {2*CUNIT}
CSEG060 cdac060 cdac061 {CUNIT}
CBIT060 cdac060 flag060 {2*CUNIT}
CSEG061 cdac061 cdac062 {CUNIT}
CBIT061 cdac061 flag061 {2*CUNIT}
CSEG062 cdac062 cdac063 {CUNIT}
CBIT062 cdac062 flag062 {2*CUNIT}
CSEG063 cdac063 cdac064 {CUNIT}
CBIT063 cdac063 flag063 {2*CUNIT}
CSEG064 cdac064 cdac065 {CUNIT}
CBIT064 cdac064 flag064 {2*CUNIT}
CSEG065 cdac065 cdac066 {CUNIT}
CBIT065 cdac065 flag065 {2*CUNIT}
CSEG066 cdac066 cdac067 {CUNIT}
CBIT066 cdac066 flag066 {2*CUNIT}
CSEG067 cdac067 cdac068 {CUNIT}
CBIT067 cdac067 flag067 {2*CUNIT}
CSEG068 cdac068 cdac069 {CUNIT}
CBIT068 cdac068 flag068 {2*CUNIT}
CSEG069 cdac069 cdac070 {CUNIT}
CBIT069 cdac069 flag069 {2*CUNIT}
CSEG070 cdac070 cdac071 {CUNIT}
CBIT070 cdac070 flag070 {2*CUNIT}
CSEG071 cdac071 cdac072 {CUNIT}
CBIT071 cdac071 flag071 {2*CUNIT}
CSEG072 cdac072 cdac073 {CUNIT}
CBIT072 cdac072 flag072 {2*CUNIT}
CSEG073 cdac073 cdac074 {CUNIT}
CBIT073 cdac073 flag073 {2*CUNIT}
CSEG074 cdac074 cdac075 {CUNIT}
CBIT074 cdac074 flag074 {2*CUNIT}
CSEG075 cdac075 cdac076 {CUNIT}
CBIT075 cdac075 flag075 {2*CUNIT}
CSEG076 cdac076 cdac077 {CUNIT}
CBIT076 cdac076 flag076 {2*CUNIT}
CSEG077 cdac077 cdac078 {CUNIT}
CBIT077 cdac077 flag077 {2*CUNIT}
CSEG078 cdac078 cdac079 {CUNIT}
CBIT078 cdac078 flag078 {2*CUNIT}
CSEG079 cdac079 cdac080 {CUNIT}
CBIT079 cdac079 flag079 {2*CUNIT}
CSEG080 cdac080 cdac081 {CUNIT}
CBIT080 cdac080 flag080 {2*CUNIT}
CSEG081 cdac081 cdac082 {CUNIT}
CBIT081 cdac081 flag081 {2*CUNIT}
CSEG082 cdac082 cdac083 {CUNIT}
CBIT082 cdac082 flag082 {2*CUNIT}
CSEG083 cdac083 cdac084 {CUNIT}
CBIT083 cdac083 flag083 {2*CUNIT}
CSEG084 cdac084 cdac085 {CUNIT}
CBIT084 cdac084 flag084 {2*CUNIT}
CSEG085 cdac085 cdac086 {CUNIT}
CBIT085 cdac085 flag085 {2*CUNIT}
CSEG086 cdac086 cdac087 {CUNIT}
CBIT086 cdac086 flag086 {2*CUNIT}
CSEG087 cdac087 cdac088 {CUNIT}
CBIT087 cdac087 flag087 {2*CUNIT}
CSEG088 cdac088 cdac089 {CUNIT}
CBIT088 cdac088 flag088 {2*CUNIT}
CSEG089 cdac089 cdac090 {CUNIT}
CBIT089 cdac089 flag089 {2*CUNIT}
CSEG090 cdac090 cdac091 {CUNIT}
CBIT090 cdac090 flag090 {2*CUNIT}
CSEG091 cdac091 cdac092 {CUNIT}
CBIT091 cdac091 flag091 {2*CUNIT}
CSEG092 cdac092 cdac093 {CUNIT}
CBIT092 cdac092 flag092 {2*CUNIT}
CSEG093 cdac093 cdac094 {CUNIT}
CBIT093 cdac093 flag093 {2*CUNIT}
CSEG094 cdac094 cdac095 {CUNIT}
CBIT094 cdac094 flag094 {2*CUNIT}
CSEG095 cdac095 cdac096 {CUNIT}
CBIT095 cdac095 flag095 {2*CUNIT}
CSEG096 cdac096 cdac097 {CUNIT}
CBIT096 cdac096 flag096 {2*CUNIT}
CSEG097 cdac097 cdac098 {CUNIT}
CBIT097 cdac097 flag097 {2*CUNIT}
CSEG098 cdac098 cdac099 {CUNIT}
CBIT098 cdac098 flag098 {2*CUNIT}
CSEG099 cdac099 cdac100 {CUNIT}
CBIT099 cdac099 flag099 {2*CUNIT}
CSEG100 cdac100 cdac101 {CUNIT}
CBIT100 cdac100 flag100 {2*CUNIT}
CSEG101 cdac101 cdac102 {CUNIT}
CBIT101 cdac101 flag101 {2*CUNIT}
CSEG102 cdac102 cdac103 {CUNIT}
CBIT102 cdac102 flag102 {2*CUNIT}
CSEG103 cdac103 cdac104 {CUNIT}
CBIT103 cdac103 flag103 {2*CUNIT}
CSEG104 cdac104 cdac105 {CUNIT}
CBIT104 cdac104 flag104 {2*CUNIT}
CSEG105 cdac105 cdac106 {CUNIT}
CBIT105 cdac105 flag105 {2*CUNIT}
CSEG106 cdac106 cdac107 {CUNIT}
CBIT106 cdac106 flag106 {2*CUNIT}
CSEG107 cdac107 cdac108 {CUNIT}
CBIT107 cdac107 flag107 {2*CUNIT}
CSEG108 cdac108 cdac109 {CUNIT}
CBIT108 cdac108 flag108 {2*CUNIT}
CSEG109 cdac109 cdac110 {CUNIT}
CBIT109 cdac109 flag109 {2*CUNIT}
CSEG110 cdac110 cdac111 {CUNIT}
CBIT110 cdac110 flag110 {2*CUNIT}
CSEG111 cdac111 cdac112 {CUNIT}
CBIT111 cdac111 flag111 {2*CUNIT}
CSEG112 cdac112 cdac113 {CUNIT}
CBIT112 cdac112 flag112 {2*CUNIT}
CSEG113 cdac113 cdac114 {CUNIT}
CBIT113 cdac113 flag113 {2*CUNIT}
CSEG114 cdac114 cdac115 {CUNIT}
CBIT114 cdac114 flag114 {2*CUNIT}
CSEG115 cdac115 cdac116 {CUNIT}
CBIT115 cdac115 flag115 {2*CUNIT}
CSEG116 cdac116 cdac117 {CUNIT}
CBIT116 cdac116 flag116 {2*CUNIT}
CSEG117 cdac117 cdac118 {CUNIT}
CBIT117 cdac117 flag117 {2*CUNIT}
CSEG118 cdac118 cdac119 {CUNIT}
CBIT118 cdac118 flag118 {2*CUNIT}
CSEG119 cdac119 cdac120 {CUNIT}
CBIT119 cdac119 flag119 {2*CUNIT}
CSEG120 cdac120 cdac121 {CUNIT}
CBIT120 cdac120 flag120 {2*CUNIT}
CSEG121 cdac121 cdac122 {CUNIT}
CBIT121 cdac121 flag121 {2*CUNIT}
CSEG122 cdac122 cdac123 {CUNIT}
CBIT122 cdac122 flag122 {2*CUNIT}
CSEG123 cdac123 cdac124 {CUNIT}
CBIT123 cdac123 flag123 {2*CUNIT}
CSEG124 cdac124 cdac125 {CUNIT}
CBIT124 cdac124 flag124 {2*CUNIT}
CSEG125 cdac125 cdac126 {CUNIT}
CBIT125 cdac125 flag125 {2*CUNIT}
CSEG126 cdac126 cdac127 {CUNIT}
CBIT126 cdac126 flag126 {2*CUNIT}
CSEG127 cdac127 cdac128 {CUNIT}
CBIT127 cdac127 flag127 {2*CUNIT}
CSEG128 cdac128 cdac129 {CUNIT}
CBIT128 cdac128 flag128 {2*CUNIT}
CSEG129 cdac129 cdac130 {CUNIT}
CBIT129 cdac129 flag129 {2*CUNIT}
CSEG130 cdac130 cdac131 {CUNIT}
CBIT130 cdac130 flag130 {2*CUNIT}
CSEG131 cdac131 cdac132 {CUNIT}
CBIT131 cdac131 flag131 {2*CUNIT}
CSEG132 cdac132 cdac133 {CUNIT}
CBIT132 cdac132 flag132 {2*CUNIT}
CSEG133 cdac133 cdac134 {CUNIT}
CBIT133 cdac133 flag133 {2*CUNIT}
CSEG134 cdac134 cdac135 {CUNIT}
CBIT134 cdac134 flag134 {2*CUNIT}
CSEG135 cdac135 cdac136 {CUNIT}
CBIT135 cdac135 flag135 {2*CUNIT}
CSEG136 cdac136 cdac137 {CUNIT}
CBIT136 cdac136 flag136 {2*CUNIT}
CSEG137 cdac137 cdac138 {CUNIT}
CBIT137 cdac137 flag137 {2*CUNIT}
CSEG138 cdac138 cdac139 {CUNIT}
CBIT138 cdac138 flag138 {2*CUNIT}
CSEG139 cdac139 cdac140 {CUNIT}
CBIT139 cdac139 flag139 {2*CUNIT}
CSEG140 cdac140 cdac141 {CUNIT}
CBIT140 cdac140 flag140 {2*CUNIT}
CSEG141 cdac141 cdac142 {CUNIT}
CBIT141 cdac141 flag141 {2*CUNIT}
CSEG142 cdac142 cdac143 {CUNIT}
CBIT142 cdac142 flag142 {2*CUNIT}
CSEG143 cdac143 cdac144 {CUNIT}
CBIT143 cdac143 flag143 {2*CUNIT}
CSEG144 cdac144 cdac145 {CUNIT}
CBIT144 cdac144 flag144 {2*CUNIT}
CSEG145 cdac145 cdac146 {CUNIT}
CBIT145 cdac145 flag145 {2*CUNIT}
CSEG146 cdac146 cdac147 {CUNIT}
CBIT146 cdac146 flag146 {2*CUNIT}
CSEG147 cdac147 cdac148 {CUNIT}
CBIT147 cdac147 flag147 {2*CUNIT}
CSEG148 cdac148 cdac149 {CUNIT}
CBIT148 cdac148 flag148 {2*CUNIT}
CSEG149 cdac149 cdac150 {CUNIT}
CBIT149 cdac149 flag149 {2*CUNIT}
CSEG150 cdac150 cdac151 {CUNIT}
CBIT150 cdac150 flag150 {2*CUNIT}
CSEG151 cdac151 cdac152 {CUNIT}
CBIT151 cdac151 flag151 {2*CUNIT}
CSEG152 cdac152 cdac153 {CUNIT}
CBIT152 cdac152 flag152 {2*CUNIT}
CSEG153 cdac153 cdac154 {CUNIT}
CBIT153 cdac153 flag153 {2*CUNIT}
CSEG154 cdac154 cdac155 {CUNIT}
CBIT154 cdac154 flag154 {2*CUNIT}
CSEG155 cdac155 cdac156 {CUNIT}
CBIT155 cdac155 flag155 {2*CUNIT}
CSEG156 cdac156 cdac157 {CUNIT}
CBIT156 cdac156 flag156 {2*CUNIT}
CSEG157 cdac157 cdac158 {CUNIT}
CBIT157 cdac157 flag157 {2*CUNIT}
CSEG158 cdac158 cdac159 {CUNIT}
CBIT158 cdac158 flag158 {2*CUNIT}
CSEG159 cdac159 cdac160 {CUNIT}
CBIT159 cdac159 flag159 {2*CUNIT}
CSEG160 cdac160 cdac161 {CUNIT}
CBIT160 cdac160 flag160 {2*CUNIT}
CSEG161 cdac161 cdac162 {CUNIT}
CBIT161 cdac161 flag161 {2*CUNIT}
CSEG162 cdac162 cdac163 {CUNIT}
CBIT162 cdac162 flag162 {2*CUNIT}
CSEG163 cdac163 cdac164 {CUNIT}
CBIT163 cdac163 flag163 {2*CUNIT}
CSEG164 cdac164 cdac165 {CUNIT}
CBIT164 cdac164 flag164 {2*CUNIT}
CSEG165 cdac165 cdac166 {CUNIT}
CBIT165 cdac165 flag165 {2*CUNIT}
CSEG166 cdac166 cdac167 {CUNIT}
CBIT166 cdac166 flag166 {2*CUNIT}
CSEG167 cdac167 cdac168 {CUNIT}
CBIT167 cdac167 flag167 {2*CUNIT}
CSEG168 cdac168 cdac169 {CUNIT}
CBIT168 cdac168 flag168 {2*CUNIT}
CSEG169 cdac169 cdac170 {CUNIT}
CBIT169 cdac169 flag169 {2*CUNIT}
CSEG170 cdac170 cdac171 {CUNIT}
CBIT170 cdac170 flag170 {2*CUNIT}
CSEG171 cdac171 cdac172 {CUNIT}
CBIT171 cdac171 flag171 {2*CUNIT}
CSEG172 cdac172 cdac173 {CUNIT}
CBIT172 cdac172 flag172 {2*CUNIT}
CSEG173 cdac173 cdac174 {CUNIT}
CBIT173 cdac173 flag173 {2*CUNIT}
CSEG174 cdac174 cdac175 {CUNIT}
CBIT174 cdac174 flag174 {2*CUNIT}
CSEG175 cdac175 cdac176 {CUNIT}
CBIT175 cdac175 flag175 {2*CUNIT}
CSEG176 cdac176 cdac177 {CUNIT}
CBIT176 cdac176 flag176 {2*CUNIT}
CSEG177 cdac177 cdac178 {CUNIT}
CBIT177 cdac177 flag177 {2*CUNIT}
CSEG178 cdac178 cdac179 {CUNIT}
CBIT178 cdac178 flag178 {2*CUNIT}
CSEG179 cdac179 cdac180 {CUNIT}
CBIT179 cdac179 flag179 {2*CUNIT}
CSEG180 cdac180 cdac181 {CUNIT}
CBIT180 cdac180 flag180 {2*CUNIT}
CSEG181 cdac181 cdac182 {CUNIT}
CBIT181 cdac181 flag181 {2*CUNIT}
CSEG182 cdac182 cdac183 {CUNIT}
CBIT182 cdac182 flag182 {2*CUNIT}
CSEG183 cdac183 cdac184 {CUNIT}
CBIT183 cdac183 flag183 {2*CUNIT}
CSEG184 cdac184 cdac185 {CUNIT}
CBIT184 cdac184 flag184 {2*CUNIT}
CSEG185 cdac185 cdac186 {CUNIT}
CBIT185 cdac185 flag185 {2*CUNIT}
CSEG186 cdac186 cdac187 {CUNIT}
CBIT186 cdac186 flag186 {2*CUNIT}
CSEG187 cdac187 cdac188 {CUNIT}
CBIT187 cdac187 flag187 {2*CUNIT}
CSEG188 cdac188 cdac189 {CUNIT}
CBIT188 cdac188 flag188 {2*CUNIT}
CSEG189 cdac189 cdac190 {CUNIT}
CBIT189 cdac189 flag189 {2*CUNIT}
CSEG190 cdac190 cdac191 {CUNIT}
CBIT190 cdac190 flag190 {2*CUNIT}
CSEG191 cdac191 cdac192 {CUNIT}
CBIT191 cdac191 flag191 {2*CUNIT}
CSEG192 cdac192 cdac193 {CUNIT}
CBIT192 cdac192 flag192 {2*CUNIT}
CSEG193 cdac193 cdac194 {CUNIT}
CBIT193 cdac193 flag193 {2*CUNIT}
CSEG194 cdac194 cdac195 {CUNIT}
CBIT194 cdac194 flag194 {2*CUNIT}
CSEG195 cdac195 cdac196 {CUNIT}
CBIT195 cdac195 flag195 {2*CUNIT}
CSEG196 cdac196 cdac197 {CUNIT}
CBIT196 cdac196 flag196 {2*CUNIT}
CSEG197 cdac197 cdac198 {CUNIT}
CBIT197 cdac197 flag197 {2*CUNIT}
CSEG198 cdac198 cdac199 {CUNIT}
CBIT198 cdac198 flag198 {2*CUNIT}
CSEG199 cdac199 cdac200 {CUNIT}
CBIT199 cdac199 flag199 {2*CUNIT}
CSEG200 cdac200 cdac201 {CUNIT}
CBIT200 cdac200 flag200 {2*CUNIT}
CSEG201 cdac201 cdac202 {CUNIT}
CBIT201 cdac201 flag201 {2*CUNIT}
CSEG202 cdac202 cdac203 {CUNIT}
CBIT202 cdac202 flag202 {2*CUNIT}
CSEG203 cdac203 cdac204 {CUNIT}
CBIT203 cdac203 flag203 {2*CUNIT}
CSEG204 cdac204 cdac205 {CUNIT}
CBIT204 cdac204 flag204 {2*CUNIT}
CSEG205 cdac205 cdac206 {CUNIT}
CBIT205 cdac205 flag205 {2*CUNIT}
CSEG206 cdac206 cdac207 {CUNIT}
CBIT206 cdac206 flag206 {2*CUNIT}
CSEG207 cdac207 cdac208 {CUNIT}
CBIT207 cdac207 flag207 {2*CUNIT}
CSEG208 cdac208 cdac209 {CUNIT}
CBIT208 cdac208 flag208 {2*CUNIT}
CSEG209 cdac209 cdac210 {CUNIT}
CBIT209 cdac209 flag209 {2*CUNIT}
CSEG210 cdac210 cdac211 {CUNIT}
CBIT210 cdac210 flag210 {2*CUNIT}
CSEG211 cdac211 cdac212 {CUNIT}
CBIT211 cdac211 flag211 {2*CUNIT}
CSEG212 cdac212 cdac213 {CUNIT}
CBIT212 cdac212 flag212 {2*CUNIT}
CSEG213 cdac213 cdac214 {CUNIT}
CBIT213 cdac213 flag213 {2*CUNIT}
CSEG214 cdac214 cdac215 {CUNIT}
CBIT214 cdac214 flag214 {2*CUNIT}
CSEG215 cdac215 cdac216 {CUNIT}
CBIT215 cdac215 flag215 {2*CUNIT}
CSEG216 cdac216 cdac217 {CUNIT}
CBIT216 cdac216 flag216 {2*CUNIT}
CSEG217 cdac217 cdac218 {CUNIT}
CBIT217 cdac217 flag217 {2*CUNIT}
CSEG218 cdac218 cdac219 {CUNIT}
CBIT218 cdac218 flag218 {2*CUNIT}
CSEG219 cdac219 cdac220 {CUNIT}
CBIT219 cdac219 flag219 {2*CUNIT}
CSEG220 cdac220 cdac221 {CUNIT}
CBIT220 cdac220 flag220 {2*CUNIT}
CSEG221 cdac221 cdac222 {CUNIT}
CBIT221 cdac221 flag221 {2*CUNIT}
CSEG222 cdac222 cdac223 {CUNIT}
CBIT222 cdac222 flag222 {2*CUNIT}
CSEG223 cdac223 cdac224 {CUNIT}
CBIT223 cdac223 flag223 {2*CUNIT}
CSEG224 cdac224 cdac225 {CUNIT}
CBIT224 cdac224 flag224 {2*CUNIT}
CSEG225 cdac225 cdac226 {CUNIT}
CBIT225 cdac225 flag225 {2*CUNIT}
CSEG226 cdac226 cdac227 {CUNIT}
CBIT226 cdac226 flag226 {2*CUNIT}
CSEG227 cdac227 cdac228 {CUNIT}
CBIT227 cdac227 flag227 {2*CUNIT}
CSEG228 cdac228 cdac229 {CUNIT}
CBIT228 cdac228 flag228 {2*CUNIT}
CSEG229 cdac229 cdac230 {CUNIT}
CBIT229 cdac229 flag229 {2*CUNIT}
CSEG230 cdac230 cdac231 {CUNIT}
CBIT230 cdac230 flag230 {2*CUNIT}
CSEG231 cdac231 cdac232 {CUNIT}
CBIT231 cdac231 flag231 {2*CUNIT}
CSEG232 cdac232 cdac233 {CUNIT}
CBIT232 cdac232 flag232 {2*CUNIT}
CSEG233 cdac233 cdac234 {CUNIT}
CBIT233 cdac233 flag233 {2*CUNIT}
CSEG234 cdac234 cdac235 {CUNIT}
CBIT234 cdac234 flag234 {2*CUNIT}
CSEG235 cdac235 cdac236 {CUNIT}
CBIT235 cdac235 flag235 {2*CUNIT}
CSEG236 cdac236 cdac237 {CUNIT}
CBIT236 cdac236 flag236 {2*CUNIT}
CSEG237 cdac237 cdac238 {CUNIT}
CBIT237 cdac237 flag237 {2*CUNIT}
CSEG238 cdac238 cdac239 {CUNIT}
CBIT238 cdac238 flag238 {2*CUNIT}
CSEG239 cdac239 cdac240 {CUNIT}
CBIT239 cdac239 flag239 {2*CUNIT}
CSEG240 cdac240 cdac241 {CUNIT}
CBIT240 cdac240 flag240 {2*CUNIT}
CSEG241 cdac241 cdac242 {CUNIT}
CBIT241 cdac241 flag241 {2*CUNIT}
CSEG242 cdac242 cdac243 {CUNIT}
CBIT242 cdac242 flag242 {2*CUNIT}
CSEG243 cdac243 cdac244 {CUNIT}
CBIT243 cdac243 flag243 {2*CUNIT}
CSEG244 cdac244 cdac245 {CUNIT}
CBIT244 cdac244 flag244 {2*CUNIT}
CSEG245 cdac245 cdac246 {CUNIT}
CBIT245 cdac245 flag245 {2*CUNIT}
CSEG246 cdac246 cdac247 {CUNIT}
CBIT246 cdac246 flag246 {2*CUNIT}
CSEG247 cdac247 cdac248 {CUNIT}
CBIT247 cdac247 flag247 {2*CUNIT}
CSEG248 cdac248 cdac249 {CUNIT}
CBIT248 cdac248 flag248 {2*CUNIT}
CSEG249 cdac249 cdac250 {CUNIT}
CBIT249 cdac249 flag249 {2*CUNIT}
CSEG250 cdac250 cdac251 {CUNIT}
CBIT250 cdac250 flag250 {2*CUNIT}
CSEG251 cdac251 cdac252 {CUNIT}
CBIT251 cdac251 flag251 {2*CUNIT}
CSEG252 cdac252 cdac253 {CUNIT}
CBIT252 cdac252 flag252 {2*CUNIT}
CSEG253 cdac253 cdac254 {CUNIT}
CBIT253 cdac253 flag253 {2*CUNIT}
CSEG254 cdac254 cdac255 {CUNIT}
CBIT254 cdac254 flag254 {2*CUNIT}
CSEG255 cdac255 cdac256 {CUNIT}
CBIT255 cdac255 flag255 {2*CUNIT}
CSEG256 cdac256 cdac257 {CUNIT}
CBIT256 cdac256 flag256 {2*CUNIT}
CSEG257 cdac257 cdac258 {CUNIT}
CBIT257 cdac257 flag257 {2*CUNIT}
CSEG258 cdac258 cdac259 {CUNIT}
CBIT258 cdac258 flag258 {2*CUNIT}
CSEG259 cdac259 cdac260 {CUNIT}
CBIT259 cdac259 flag259 {2*CUNIT}
CSEG260 cdac260 cdac261 {CUNIT}
CBIT260 cdac260 flag260 {2*CUNIT}
CSEG261 cdac261 cdac262 {CUNIT}
CBIT261 cdac261 flag261 {2*CUNIT}
CSEG262 cdac262 cdac263 {CUNIT}
CBIT262 cdac262 flag262 {2*CUNIT}
CSEG263 cdac263 cdac264 {CUNIT}
CBIT263 cdac263 flag263 {2*CUNIT}
CSEG264 cdac264 cdac265 {CUNIT}
CBIT264 cdac264 flag264 {2*CUNIT}
CSEG265 cdac265 cdac266 {CUNIT}
CBIT265 cdac265 flag265 {2*CUNIT}
CSEG266 cdac266 cdac267 {CUNIT}
CBIT266 cdac266 flag266 {2*CUNIT}
CSEG267 cdac267 cdac268 {CUNIT}
CBIT267 cdac267 flag267 {2*CUNIT}
CSEG268 cdac268 cdac269 {CUNIT}
CBIT268 cdac268 flag268 {2*CUNIT}
CSEG269 cdac269 cdac270 {CUNIT}
CBIT269 cdac269 flag269 {2*CUNIT}
CSEG270 cdac270 cdac271 {CUNIT}
CBIT270 cdac270 flag270 {2*CUNIT}
CSEG271 cdac271 cdac272 {CUNIT}
CBIT271 cdac271 flag271 {2*CUNIT}
CSEG272 cdac272 cdac273 {CUNIT}
CBIT272 cdac272 flag272 {2*CUNIT}
CSEG273 cdac273 cdac274 {CUNIT}
CBIT273 cdac273 flag273 {2*CUNIT}
CSEG274 cdac274 cdac275 {CUNIT}
CBIT274 cdac274 flag274 {2*CUNIT}
CSEG275 cdac275 cdac276 {CUNIT}
CBIT275 cdac275 flag275 {2*CUNIT}
CSEG276 cdac276 cdac277 {CUNIT}
CBIT276 cdac276 flag276 {2*CUNIT}
CSEG277 cdac277 cdac278 {CUNIT}
CBIT277 cdac277 flag277 {2*CUNIT}
CSEG278 cdac278 cdac279 {CUNIT}
CBIT278 cdac278 flag278 {2*CUNIT}
CSEG279 cdac279 cdac280 {CUNIT}
CBIT279 cdac279 flag279 {2*CUNIT}
CSEG280 cdac280 cdac281 {CUNIT}
CBIT280 cdac280 flag280 {2*CUNIT}
CSEG281 cdac281 cdac282 {CUNIT}
CBIT281 cdac281 flag281 {2*CUNIT}
CSEG282 cdac282 cdac283 {CUNIT}
CBIT282 cdac282 flag282 {2*CUNIT}
CSEG283 cdac283 cdac284 {CUNIT}
CBIT283 cdac283 flag283 {2*CUNIT}
CSEG284 cdac284 cdac285 {CUNIT}
CBIT284 cdac284 flag284 {2*CUNIT}
CSEG285 cdac285 cdac286 {CUNIT}
CBIT285 cdac285 flag285 {2*CUNIT}
CSEG286 cdac286 cdac287 {CUNIT}
CBIT286 cdac286 flag286 {2*CUNIT}
CSEG287 cdac287 cdac288 {CUNIT}
CBIT287 cdac287 flag287 {2*CUNIT}
CSEG288 cdac288 cdac289 {CUNIT}
CBIT288 cdac288 flag288 {2*CUNIT}
CSEG289 cdac289 cdac290 {CUNIT}
CBIT289 cdac289 flag289 {2*CUNIT}
CSEG290 cdac290 cdac291 {CUNIT}
CBIT290 cdac290 flag290 {2*CUNIT}
CSEG291 cdac291 cdac292 {CUNIT}
CBIT291 cdac291 flag291 {2*CUNIT}
CSEG292 cdac292 cdac293 {CUNIT}
CBIT292 cdac292 flag292 {2*CUNIT}
CSEG293 cdac293 cdac294 {CUNIT}
CBIT293 cdac293 flag293 {2*CUNIT}
CSEG294 cdac294 cdac295 {CUNIT}
CBIT294 cdac294 flag294 {2*CUNIT}
CSEG295 cdac295 cdac296 {CUNIT}
CBIT295 cdac295 flag295 {2*CUNIT}
CSEG296 cdac296 cdac297 {CUNIT}
CBIT296 cdac296 flag296 {2*CUNIT}
CSEG297 cdac297 cdac298 {CUNIT}
CBIT297 cdac297 flag297 {2*CUNIT}
CSEG298 cdac298 cdac299 {CUNIT}
CBIT298 cdac298 flag298 {2*CUNIT}
CSEG299 cdac299 cdac300 {CUNIT}
CBIT299 cdac299 flag299 {2*CUNIT}
CSEG300 cdac300 cdac301 {CUNIT}
CBIT300 cdac300 flag300 {2*CUNIT}
CSEG301 cdac301 cdac302 {CUNIT}
CBIT301 cdac301 flag301 {2*CUNIT}
CSEG302 cdac302 cdac303 {CUNIT}
CBIT302 cdac302 flag302 {2*CUNIT}
CSEG303 cdac303 cdac304 {CUNIT}
CBIT303 cdac303 flag303 {2*CUNIT}
CSEG304 cdac304 cdac305 {CUNIT}
CBIT304 cdac304 flag304 {2*CUNIT}
CSEG305 cdac305 cdac306 {CUNIT}
CBIT305 cdac305 flag305 {2*CUNIT}
CSEG306 cdac306 cdac307 {CUNIT}
CBIT306 cdac306 flag306 {2*CUNIT}
CSEG307 cdac307 cdac308 {CUNIT}
CBIT307 cdac307 flag307 {2*CUNIT}
CSEG308 cdac308 cdac309 {CUNIT}
CBIT308 cdac308 flag308 {2*CUNIT}
CSEG309 cdac309 cdac310 {CUNIT}
CBIT309 cdac309 flag309 {2*CUNIT}
CSEG310 cdac310 cdac311 {CUNIT}
CBIT310 cdac310 flag310 {2*CUNIT}
CSEG311 cdac311 cdac312 {CUNIT}
CBIT311 cdac311 flag311 {2*CUNIT}
CSEG312 cdac312 cdac313 {CUNIT}
CBIT312 cdac312 flag312 {2*CUNIT}
CSEG313 cdac313 cdac314 {CUNIT}
CBIT313 cdac313 flag313 {2*CUNIT}
CSEG314 cdac314 cdac315 {CUNIT}
CBIT314 cdac314 flag314 {2*CUNIT}
CSEG315 cdac315 cdac316 {CUNIT}
CBIT315 cdac315 flag315 {2*CUNIT}
CSEG316 cdac316 cdac317 {CUNIT}
CBIT316 cdac316 flag316 {2*CUNIT}
CSEG317 cdac317 cdac318 {CUNIT}
CBIT317 cdac317 flag317 {2*CUNIT}
CSEG318 cdac318 cdac319 {CUNIT}
CBIT318 cdac318 flag318 {2*CUNIT}
CSEG319 cdac319 cdac320 {CUNIT}
CBIT319 cdac319 flag319 {2*CUNIT}
CSEG320 cdac320 cdac321 {CUNIT}
CBIT320 cdac320 flag320 {2*CUNIT}
CSEG321 cdac321 cdac322 {CUNIT}
CBIT321 cdac321 flag321 {2*CUNIT}
CSEG322 cdac322 cdac323 {CUNIT}
CBIT322 cdac322 flag322 {2*CUNIT}
CSEG323 cdac323 cdac324 {CUNIT}
CBIT323 cdac323 flag323 {2*CUNIT}
CSEG324 cdac324 cdac325 {CUNIT}
CBIT324 cdac324 flag324 {2*CUNIT}
CSEG325 cdac325 cdac326 {CUNIT}
CBIT325 cdac325 flag325 {2*CUNIT}
CSEG326 cdac326 cdac327 {CUNIT}
CBIT326 cdac326 flag326 {2*CUNIT}
CSEG327 cdac327 cdac328 {CUNIT}
CBIT327 cdac327 flag327 {2*CUNIT}
CSEG328 cdac328 cdac329 {CUNIT}
CBIT328 cdac328 flag328 {2*CUNIT}
CSEG329 cdac329 cdac330 {CUNIT}
CBIT329 cdac329 flag329 {2*CUNIT}
CSEG330 cdac330 cdac331 {CUNIT}
CBIT330 cdac330 flag330 {2*CUNIT}
CSEG331 cdac331 cdac332 {CUNIT}
CBIT331 cdac331 flag331 {2*CUNIT}
CSEG332 cdac332 cdac333 {CUNIT}
CBIT332 cdac332 flag332 {2*CUNIT}
CSEG333 cdac333 cdac334 {CUNIT}
CBIT333 cdac333 flag333 {2*CUNIT}
CSEG334 cdac334 cdac335 {CUNIT}
CBIT334 cdac334 flag334 {2*CUNIT}
CSEG335 cdac335 cdac_end {CUNIT}
CBIT335 cdac335 flag335 {2*CUNIT}
CTERM cdac_end 0 {2*CUNIT}

B_DAC circus_dac 0 V = { VREF*(
+ V(flag000)/(2**1) +
+ V(flag001)/(2**2) +
+ V(flag002)/(2**3) +
+ V(flag003)/(2**4) +
+ V(flag004)/(2**5) +
+ V(flag005)/(2**6) +
+ V(flag006)/(2**7) +
+ V(flag007)/(2**8) +
+ V(flag008)/(2**9) +
+ V(flag009)/(2**10) +
+ V(flag010)/(2**11) +
+ V(flag011)/(2**12) +
+ V(flag012)/(2**13) +
+ V(flag013)/(2**14) +
+ V(flag014)/(2**15) +
+ V(flag015)/(2**16) +
+ V(flag016)/(2**17) +
+ V(flag017)/(2**18) +
+ V(flag018)/(2**19) +
+ V(flag019)/(2**20) +
+ V(flag020)/(2**21) +
+ V(flag021)/(2**22) +
+ V(flag022)/(2**23) +
+ V(flag023)/(2**24) +
+ V(flag024)/(2**25) +
+ V(flag025)/(2**26) +
+ V(flag026)/(2**27) +
+ V(flag027)/(2**28) +
+ V(flag028)/(2**29) +
+ V(flag029)/(2**30) +
+ V(flag030)/(2**31) +
+ V(flag031)/(2**32) +
+ V(flag032)/(2**33) +
+ V(flag033)/(2**34) +
+ V(flag034)/(2**35) +
+ V(flag035)/(2**36) +
+ V(flag036)/(2**37) +
+ V(flag037)/(2**38) +
+ V(flag038)/(2**39) +
+ V(flag039)/(2**40) +
+ V(flag040)/(2**41) +
+ V(flag041)/(2**42) +
+ V(flag042)/(2**43) +
+ V(flag043)/(2**44) +
+ V(flag044)/(2**45) +
+ V(flag045)/(2**46) +
+ V(flag046)/(2**47) +
+ V(flag047)/(2**48) +
+ V(flag048)/(2**49) +
+ V(flag049)/(2**50) +
+ V(flag050)/(2**51) +
+ V(flag051)/(2**52) +
+ V(flag052)/(2**53) +
+ V(flag053)/(2**54) +
+ V(flag054)/(2**55) +
+ V(flag055)/(2**56) +
+ V(flag056)/(2**57) +
+ V(flag057)/(2**58) +
+ V(flag058)/(2**59) +
+ V(flag059)/(2**60) +
+ V(flag060)/(2**61) +
+ V(flag061)/(2**62) +
+ V(flag062)/(2**63) +
+ V(flag063)/(2**64) +
+ V(flag064)/(2**65) +
+ V(flag065)/(2**66) +
+ V(flag066)/(2**67) +
+ V(flag067)/(2**68) +
+ V(flag068)/(2**69) +
+ V(flag069)/(2**70) +
+ V(flag070)/(2**71) +
+ V(flag071)/(2**72) +
+ V(flag072)/(2**73) +
+ V(flag073)/(2**74) +
+ V(flag074)/(2**75) +
+ V(flag075)/(2**76) +
+ V(flag076)/(2**77) +
+ V(flag077)/(2**78) +
+ V(flag078)/(2**79) +
+ V(flag079)/(2**80) +
+ V(flag080)/(2**81) +
+ V(flag081)/(2**82) +
+ V(flag082)/(2**83) +
+ V(flag083)/(2**84) +
+ V(flag084)/(2**85) +
+ V(flag085)/(2**86) +
+ V(flag086)/(2**87) +
+ V(flag087)/(2**88) +
+ V(flag088)/(2**89) +
+ V(flag089)/(2**90) +
+ V(flag090)/(2**91) +
+ V(flag091)/(2**92) +
+ V(flag092)/(2**93) +
+ V(flag093)/(2**94) +
+ V(flag094)/(2**95) +
+ V(flag095)/(2**96) +
+ V(flag096)/(2**97) +
+ V(flag097)/(2**98) +
+ V(flag098)/(2**99) +
+ V(flag099)/(2**100) +
+ V(flag100)/(2**101) +
+ V(flag101)/(2**102) +
+ V(flag102)/(2**103) +
+ V(flag103)/(2**104) +
+ V(flag104)/(2**105) +
+ V(flag105)/(2**106) +
+ V(flag106)/(2**107) +
+ V(flag107)/(2**108) +
+ V(flag108)/(2**109) +
+ V(flag109)/(2**110) +
+ V(flag110)/(2**111) +
+ V(flag111)/(2**112) +
+ V(flag112)/(2**113) +
+ V(flag113)/(2**114) +
+ V(flag114)/(2**115) +
+ V(flag115)/(2**116) +
+ V(flag116)/(2**117) +
+ V(flag117)/(2**118) +
+ V(flag118)/(2**119) +
+ V(flag119)/(2**120) +
+ V(flag120)/(2**121) +
+ V(flag121)/(2**122) +
+ V(flag122)/(2**123) +
+ V(flag123)/(2**124) +
+ V(flag124)/(2**125) +
+ V(flag125)/(2**126) +
+ V(flag126)/(2**127) +
+ V(flag127)/(2**128) +
+ V(flag128)/(2**129) +
+ V(flag129)/(2**130) +
+ V(flag130)/(2**131) +
+ V(flag131)/(2**132) +
+ V(flag132)/(2**133) +
+ V(flag133)/(2**134) +
+ V(flag134)/(2**135) +
+ V(flag135)/(2**136) +
+ V(flag136)/(2**137) +
+ V(flag137)/(2**138) +
+ V(flag138)/(2**139) +
+ V(flag139)/(2**140) +
+ V(flag140)/(2**141) +
+ V(flag141)/(2**142) +
+ V(flag142)/(2**143) +
+ V(flag143)/(2**144) +
+ V(flag144)/(2**145) +
+ V(flag145)/(2**146) +
+ V(flag146)/(2**147) +
+ V(flag147)/(2**148) +
+ V(flag148)/(2**149) +
+ V(flag149)/(2**150) +
+ V(flag150)/(2**151) +
+ V(flag151)/(2**152) +
+ V(flag152)/(2**153) +
+ V(flag153)/(2**154) +
+ V(flag154)/(2**155) +
+ V(flag155)/(2**156) +
+ V(flag156)/(2**157) +
+ V(flag157)/(2**158) +
+ V(flag158)/(2**159) +
+ V(flag159)/(2**160) +
+ V(flag160)/(2**161) +
+ V(flag161)/(2**162) +
+ V(flag162)/(2**163) +
+ V(flag163)/(2**164) +
+ V(flag164)/(2**165) +
+ V(flag165)/(2**166) +
+ V(flag166)/(2**167) +
+ V(flag167)/(2**168) +
+ V(flag168)/(2**169) +
+ V(flag169)/(2**170) +
+ V(flag170)/(2**171) +
+ V(flag171)/(2**172) +
+ V(flag172)/(2**173) +
+ V(flag173)/(2**174) +
+ V(flag174)/(2**175) +
+ V(flag175)/(2**176) +
+ V(flag176)/(2**177) +
+ V(flag177)/(2**178) +
+ V(flag178)/(2**179) +
+ V(flag179)/(2**180) +
+ V(flag180)/(2**181) +
+ V(flag181)/(2**182) +
+ V(flag182)/(2**183) +
+ V(flag183)/(2**184) +
+ V(flag184)/(2**185) +
+ V(flag185)/(2**186) +
+ V(flag186)/(2**187) +
+ V(flag187)/(2**188) +
+ V(flag188)/(2**189) +
+ V(flag189)/(2**190) +
+ V(flag190)/(2**191) +
+ V(flag191)/(2**192) +
+ V(flag192)/(2**193) +
+ V(flag193)/(2**194) +
+ V(flag194)/(2**195) +
+ V(flag195)/(2**196) +
+ V(flag196)/(2**197) +
+ V(flag197)/(2**198) +
+ V(flag198)/(2**199) +
+ V(flag199)/(2**200) +
+ V(flag200)/(2**201) +
+ V(flag201)/(2**202) +
+ V(flag202)/(2**203) +
+ V(flag203)/(2**204) +
+ V(flag204)/(2**205) +
+ V(flag205)/(2**206) +
+ V(flag206)/(2**207) +
+ V(flag207)/(2**208) +
+ V(flag208)/(2**209) +
+ V(flag209)/(2**210) +
+ V(flag210)/(2**211) +
+ V(flag211)/(2**212) +
+ V(flag212)/(2**213) +
+ V(flag213)/(2**214) +
+ V(flag214)/(2**215) +
+ V(flag215)/(2**216) +
+ V(flag216)/(2**217) +
+ V(flag217)/(2**218) +
+ V(flag218)/(2**219) +
+ V(flag219)/(2**220) +
+ V(flag220)/(2**221) +
+ V(flag221)/(2**222) +
+ V(flag222)/(2**223) +
+ V(flag223)/(2**224) +
+ V(flag224)/(2**225) +
+ V(flag225)/(2**226) +
+ V(flag226)/(2**227) +
+ V(flag227)/(2**228) +
+ V(flag228)/(2**229) +
+ V(flag229)/(2**230) +
+ V(flag230)/(2**231) +
+ V(flag231)/(2**232) +
+ V(flag232)/(2**233) +
+ V(flag233)/(2**234) +
+ V(flag234)/(2**235) +
+ V(flag235)/(2**236) +
+ V(flag236)/(2**237) +
+ V(flag237)/(2**238) +
+ V(flag238)/(2**239) +
+ V(flag239)/(2**240) +
+ V(flag240)/(2**241) +
+ V(flag241)/(2**242) +
+ V(flag242)/(2**243) +
+ V(flag243)/(2**244) +
+ V(flag244)/(2**245) +
+ V(flag245)/(2**246) +
+ V(flag246)/(2**247) +
+ V(flag247)/(2**248) +
+ V(flag248)/(2**249) +
+ V(flag249)/(2**250) +
+ V(flag250)/(2**251) +
+ V(flag251)/(2**252) +
+ V(flag252)/(2**253) +
+ V(flag253)/(2**254) +
+ V(flag254)/(2**255) +
+ V(flag255)/(2**256) +
+ V(flag256)/(2**257) +
+ V(flag257)/(2**258) +
+ V(flag258)/(2**259) +
+ V(flag259)/(2**260) +
+ V(flag260)/(2**261) +
+ V(flag261)/(2**262) +
+ V(flag262)/(2**263) +
+ V(flag263)/(2**264) +
+ V(flag264)/(2**265) +
+ V(flag265)/(2**266) +
+ V(flag266)/(2**267) +
+ V(flag267)/(2**268) +
+ V(flag268)/(2**269) +
+ V(flag269)/(2**270) +
+ V(flag270)/(2**271) +
+ V(flag271)/(2**272) +
+ V(flag272)/(2**273) +
+ V(flag273)/(2**274) +
+ V(flag274)/(2**275) +
+ V(flag275)/(2**276) +
+ V(flag276)/(2**277) +
+ V(flag277)/(2**278) +
+ V(flag278)/(2**279) +
+ V(flag279)/(2**280) +
+ V(flag280)/(2**281) +
+ V(flag281)/(2**282) +
+ V(flag282)/(2**283) +
+ V(flag283)/(2**284) +
+ V(flag284)/(2**285) +
+ V(flag285)/(2**286) +
+ V(flag286)/(2**287) +
+ V(flag287)/(2**288) +
+ V(flag288)/(2**289) +
+ V(flag289)/(2**290) +
+ V(flag290)/(2**291) +
+ V(flag291)/(2**292) +
+ V(flag292)/(2**293) +
+ V(flag293)/(2**294) +
+ V(flag294)/(2**295) +
+ V(flag295)/(2**296) +
+ V(flag296)/(2**297) +
+ V(flag297)/(2**298) +
+ V(flag298)/(2**299) +
+ V(flag299)/(2**300) +
+ V(flag300)/(2**301) +
+ V(flag301)/(2**302) +
+ V(flag302)/(2**303) +
+ V(flag303)/(2**304) +
+ V(flag304)/(2**305) +
+ V(flag305)/(2**306) +
+ V(flag306)/(2**307) +
+ V(flag307)/(2**308) +
+ V(flag308)/(2**309) +
+ V(flag309)/(2**310) +
+ V(flag310)/(2**311) +
+ V(flag311)/(2**312) +
+ V(flag312)/(2**313) +
+ V(flag313)/(2**314) +
+ V(flag314)/(2**315) +
+ V(flag315)/(2**316) +
+ V(flag316)/(2**317) +
+ V(flag317)/(2**318) +
+ V(flag318)/(2**319) +
+ V(flag319)/(2**320) +
+ V(flag320)/(2**321) +
+ V(flag321)/(2**322) +
+ V(flag322)/(2**323) +
+ V(flag323)/(2**324) +
+ V(flag324)/(2**325) +
+ V(flag325)/(2**326) +
+ V(flag326)/(2**327) +
+ V(flag327)/(2**328) +
+ V(flag328)/(2**329) +
+ V(flag329)/(2**330) +
+ V(flag330)/(2**331) +
+ V(flag331)/(2**332) +
+ V(flag332)/(2**333) +
+ V(flag333)/(2**334) +
+ V(flag334)/(2**335) +
+ V(flag335)/(2**336)
+ 0 ) }

R001 circus_dac n001 144761
R002 n001 n002 302441
R003 n002 n003 607994
R004 n003 n004 370672
R005 n004 n005 520635
R006 n005 n006 823185
R007 n006 n007 593063
R008 n007 n008 129449
R009 n008 n009 431422
R010 n009 n010 192812
R011 n010 n011 720171
R012 n011 n012 474610
R013 n012 n013 254360
R014 n013 n014 10767
R015 n014 n015 365515
R016 n015 n016 853480
R017 n016 n017 903772
R018 n017 n018 98183
R019 n018 n019 484669
R020 n019 n020 390395
R021 n020 n021 277696
R022 n021 n022 468578
R023 n022 n023 554554
R024 n023 n024 79119
R025 n024 n025 808295
R026 n025 n026 894137
R027 n026 n027 827297
R028 n027 n028 132018
R029 n028 n029 754667
R030 n029 n030 772287
R031 n030 n031 456990
R032 n031 n032 48930
R033 n032 n033 397252
R034 n033 n034 652692
R035 n034 n035 228522
R036 n035 n036 516300
R037 n036 n037 75975
R038 n037 n038 229215
R039 n038 n039 689730
R040 n039 n040 700742
R041 n040 n041 399232
R042 n041 n042 50256
R043 n042 n043 817523
R044 n043 n044 810155
R045 n044 net_tap 236755
R046 net_tap 0 832470
R047 circus_dac n006 309276
R048 circus_dac n011 890906
R049 circus_dac n016 518327
R050 circus_dac n021 481584
R051 circus_dac n026 433120
R052 circus_dac n031 761007
R053 circus_dac n036 600822
R054 circus_dac n041 463700
R055 n003 0 263052
R056 n009 0 405155
R057 n015 0 639465
R058 n021 0 564077
R059 n027 0 598945
R060 n033 0 903790
R061 n039 0 244922
R062 n004 net_tap 569170
R063 n011 net_tap 878066
R064 n018 net_tap 817659
R065 n025 net_tap 203914
R066 n032 net_tap 129153
R067 n039 net_tap 409510
R068 n028 n035 354789
R069 n043 n040 671161
R070 n021 n004 123275
R071 n027 circus_dac 490786
R072 n016 n025 179218
R073 n040 n013 352641
R074 n017 n037 361976
R075 n021 n028 49419
R076 n028 n016 627614
R077 n043 n021 800768
R078 n014 n017 760701
R079 n003 n043 547969
R080 n034 n031 150217
R081 n019 n040 168948
R082 n025 n029 744896
R083 n028 0 216322
R084 n030 n003 690044
R085 n027 n041 868396
R086 n039 n001 884239
R087 n028 n020 95924
R088 n041 n029 806056
R089 n036 n023 35727
R090 n025 n012 85024
R091 n035 n013 441818
R092 n028 n032 523273
R093 net_tap n022 334649
R094 n044 n005 532585
R095 n037 n030 133789
R096 n008 n032 176026
R097 n023 n021 303045
R098 n013 0 886099
R099 n011 n031 105777
R100 n012 n038 809408
R101 n039 n004 481728
R102 n040 0 229007
R103 n030 n041 198879
R104 n026 n044 185149
R105 n028 n022 663113
R106 n008 n029 244915
R107 n043 n024 511710
R108 n008 n028 290486
R109 n020 n004 26203
R110 n021 n011 690138
R111 n010 n002 629905
R112 n003 circus_dac 540602
R113 n040 n001 93280
R114 n018 n007 813007
R115 net_tap n003 875706
R116 n036 n004 498880
R117 n018 n024 37560
R118 n007 n009 821128
R119 n006 n040 337737
R120 n036 n040 13299
R121 n038 n013 137160
R122 n041 n005 137082
R123 n021 n003 342036
R124 n001 n010 385805
R125 n009 n023 858063
R126 n018 n040 840744
R127 n024 n020 585102
R128 n004 n010 859410
R129 n002 n040 869448
R130 n030 n036 440167
R131 n013 n018 159692
R132 n043 n028 374844
R133 n041 n044 302846
R134 n042 circus_dac 510952
R135 n012 n023 489685
R136 n029 n022 60638
R137 n035 0 463154
R138 n028 net_tap 83306
R139 n004 n006 835986
R140 net_tap n023 778056
R141 n032 circus_dac 751533
R142 n012 n019 140926
R143 n001 n037 300363
R144 n037 n031 577845
R145 n014 n040 705751
R146 n015 n013 79619
R147 n002 n037 851480
R148 n009 n004 256555
R149 n004 n033 562815
R150 n004 n044 168494
R151 n002 n029 504414
R152 n029 n016 339467
R153 n023 n005 258823
R154 n011 n018 548460
R155 n037 n003 783904
R156 n024 n005 223324
R157 n020 n027 166595
R158 n002 n032 481529
R159 n006 n026 661447
R160 n036 n002 263534
R161 n006 n035 701932
R162 n038 n042 389519
R163 n015 n040 382164
R164 n003 n029 418039
R165 n020 0 371872
R166 n041 n032 656022
R167 n026 n015 219295
R168 n033 n014 347270
R169 n042 net_tap 211388
R170 net_tap n015 619691
R171 n002 n017 469084
R172 n005 n040 55927
R173 n023 n011 900649
R174 n017 n028 237635
R175 n017 n027 908910
R176 n026 n017 91213
R177 n005 circus_dac 260087
R178 n021 n038 744545
R179 n014 n026 90637
R180 n007 n030 725192
R181 n036 n018 546430
R182 n044 n034 810514
R183 n031 n022 534545
R184 n013 n017 452351
R185 n026 n035 840336
R186 n029 n042 214508
R187 n016 n011 439424
R188 n034 n025 325733
R189 n003 n020 829781
R190 net_tap n009 620624
R191 n026 n039 441496
R192 n005 n015 218152
R193 0 n034 680424
R194 n023 n031 231406
R195 n015 n030 569463
R196 n038 n005 825276
R197 n021 n030 67691
R198 n043 n016 165878
R199 0 n036 374528
R200 n040 n011 791883
R201 n023 n002 90496
R202 n014 n032 831669
R203 0 n030 558010
R204 n020 n042 561532
R205 n002 n022 170714
R206 n024 n044 476157
R207 n009 n015 668304
R208 n028 n012 74092
R209 n029 n015 217736
R210 n031 n042 657259
R211 n036 n011 800819
R212 n014 n038 111475
R213 n029 n005 798091
R214 n038 n017 653287
R215 n024 n040 557165
R216 n031 n024 74972
R217 n036 n034 368295
R218 n018 n009 535210
R219 n023 n042 100380
R220 0 n022 878525
R221 n044 n017 104602
R222 n039 n016 359237
R223 n040 n034 610325
R224 n036 n025 440702
R225 n006 n011 894207
R226 n014 n025 118653
R_U1_BIAS net_tap 0 1300999

.model NCLOWN NMOS LEVEL=1 VTO=0.37 KP=83u LAMBDA=0
.model PCLOWN PMOS LEVEL=1 VTO=-0.41 KP=47u LAMBDA=0

.param U1_A=700000043 U1_RG=9137 U1_RF=9821
E_U1 u1_out 0 net_tap u1_n {U1_A}
R_U1_G u1_n 0 {U1_RG}
R_U1_F u1_out u1_n {U1_RF}

.param CM1_WR=8 CM1_LR=3 CM1_WO=11 CM1_LO=4 CM1_RSET=18713 CM1_RLOAD=5711
G_CM1 cm1_out 0 u1_out 0 {((CM1_WO/CM1_LO)/(CM1_WR/CM1_LR))/CM1_RSET}
R_CM1_LOAD cm1_out 0 {CM1_RLOAD}
R_CM1_SET_DUMMY u1_out cm1_sink {CM1_RSET}
V_CM1_SINK cm1_sink 0 0
M_CM1_REF cm1_ref cm1_ref 0 0 NCLOWN W=8u L=3u
M_CM1_OUT cm1_shadow cm1_ref 0 0 NCLOWN W=11u L=4u

.param U2_A=850000021 U2_RIN=12011 U2_RF=24851
E_U2 u2_out 0 0 u2_n {U2_A}
R_U2_IN cm1_out u2_n {U2_RIN}
R_U2_F u2_out u2_n {U2_RF}

.param CM2_WR=5 CM2_LR=2 CM2_WO=13 CM2_LO=3 CM2_RSET=21089 CM2_RLOAD=4987
G_CM2 0 cm2_out u2_out 0 {((CM2_WO/CM2_LO)/(CM2_WR/CM2_LR))/CM2_RSET}
R_CM2_LOAD cm2_out 0 {CM2_RLOAD}
R_CM2_SET_DUMMY u2_out cm2_sink {CM2_RSET}
V_CM2_SINK cm2_sink 0 0
M_CM2_REF cm2_ref cm2_ref vdd vdd PCLOWN W=5u L=2u
M_CM2_OUT cm2_shadow cm2_ref vdd vdd PCLOWN W=13u L=3u

.param U3_A=930000011 U3_RG=15511 U3_RF=19037
E_U3 u3_out 0 cm2_out u3_n {U3_A}
R_U3_G u3_n 0 {U3_RG}
R_U3_F u3_out u3_n {U3_RF}

.param CM3_WR=9 CM3_LR=5 CM3_WO=7 CM3_LO=4 CM3_RSET=17401 CM3_RLOAD=3907
G_CM3 cm3_out 0 u3_out 0 {((CM3_WO/CM3_LO)/(CM3_WR/CM3_LR))/CM3_RSET}
R_CM3_LOAD cm3_out 0 {CM3_RLOAD}
R_CM3_SET_DUMMY u3_out cm3_sink {CM3_RSET}
V_CM3_SINK cm3_sink 0 0
M_CM3_REF cm3_ref cm3_ref 0 0 NCLOWN W=9u L=5u
M_CM3_OUT cm3_shadow cm3_ref 0 0 NCLOWN W=7u L=4u

.param U4_A=760000033 U4_RIN=22307 U4_RF=40163
E_U4 final_out 0 0 u4_n {U4_A}
R_U4_IN cm3_out u4_n {U4_RIN}
R_U4_F final_out u4_n {U4_RF}

VDD vdd 0 DC 5
.end
